C1 v_cap 0 1e-12
R1 v_in v_cap 1e6
V1 v_in 0 pulse (0 1.5 100n 0.5n 0.5n 200n 2)
.end
