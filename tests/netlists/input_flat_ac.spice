C1 v_cap 0 1e-12
R1 v_in v_cap 1e6
V1 v_in 0 dc 1 ac 1
E1 v_out 0 v_cap 0 10e4
.end
